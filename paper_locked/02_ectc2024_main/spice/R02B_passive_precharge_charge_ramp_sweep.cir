* R02B - bounded passive-precharge sweep for the P24 four-phase module
* BASELINE: R02A, same generalized IPEC-2018 Fig. 8(e) startup network.
* PURPOSE: determine whether a region exists where the fixed 53.8-uF flying
* banks acquire the descending 3:2:1 ladder while input surge is reduced.
*
* FIXED BOUNDARIES
* P24-FIG3: four-phase/three-flying-capacitor target architecture.
* EPE2019-TABLE1 CROSS-SOURCE CANDIDATE: CFLY=53.8 uF; not a P24 value.
* IPEC2018-TABLE2: LPAR=5 nH and RPAR=10 mOhm transferred unchanged.
* IPEC2018-FIG2/FIG8/TEXT: passive input-divider/diode precharge principle.
* NUMERICAL-ONLY: ideal diodes and 1-GOhm DC-reference leakage.
* All capacitors start at 0 V using UIC. No IC=36/24/12 V. No PWM.
*
* ONLY SWEPT VARIABLES
* CDIV: 10 uF repeats failed R02A; 53.8 uF tests 1:1; 538 uF preserves
* the demonstrated IPEC 10:1 divider/flying ratio; 1.076 mF tests 20:1.
* TRAMP: 1 us repeats IPEC fast-ramp case; 10 us and 100 us test whether
* source slew can reduce peak current without changing stored-charge targets.

.param VIN=48 CFLY=53.8u LPAR=5n RPAR=10m RLEAK=1G
.step param CDIV list 10u 53.8u 538u 1.076m
.step param TRAMP list 1u 10u 100u

VSTEP src 0 PWL(0 0 {TRAMP} {VIN} 500u {VIN})
RPAR_IN src src_r {RPAR}
LPAR_IN src_r vin {LPAR}

CIN1 vin tap3 {CDIV}
CIN2 tap3 tap2 {CDIV}
CIN3 tap2 tap1 {CDIV}
CIN4 tap1 0 {CDIV}
RLEAK1 vin tap3 {RLEAK}
RLEAK2 tap3 tap2 {RLEAK}
RLEAK3 tap2 tap1 {RLEAK}
RLEAK4 tap1 0 {RLEAK}

DPC1 tap3 vc1 DPRE
DPC2 tap2 vc2 DPRE
DPC3 tap1 vc3 DPRE
CF1 vc1 0 {CFLY}
CF2 vc2 0 {CFLY}
CF3 vc3 0 {CFLY}
.model DPRE D(Ron=1m Roff=1T Vfwd=0)

.meas tran VC1_FINAL AVG V(vc1) FROM 490u TO 500u
.meas tran VC2_FINAL AVG V(vc2) FROM 490u TO 500u
.meas tran VC3_FINAL AVG V(vc3) FROM 490u TO 500u
.meas tran RATIO21 PARAM VC2_FINAL/VC1_FINAL
.meas tran RATIO31 PARAM VC3_FINAL/VC1_FINAL
.meas tran LADDER_ERR PARAM abs(VC1_FINAL-36)/36+abs(VC2_FINAL-24)/24+abs(VC3_FINAL-12)/12
.meas tran IIN_PK MAX -I(VSTEP) FROM 0 TO 500u
.meas tran ID1_PK MAX I(DPC1) FROM 0 TO 500u
.meas tran ID2_PK MAX I(DPC2) FROM 0 TO 500u
.meas tran ID3_PK MAX I(DPC3) FROM 0 TO 500u

.options reltol=1e-5 abstol=1e-10 chgtol=1e-16
.save V(vin) V(vc1) V(vc2) V(vc3) I(VSTEP) I(DPC1) I(DPC2) I(DPC3)
.tran 0 500u 0 10n UIC
.end
