* R04E4 - zero-start QH1 gate-off threshold sweep, P24-minimal branch
* CHANGE FROM R04E3: I_GATE_OFF only. Original R04E3 remains unchanged.
* PURPOSE: map commanded turn-off current to post-commutation physical peak.

.include ../../04_component_models/GS61008T_typical_params.lib
.param VIN=48 VOUT_REF=1 POUT_MODULE=250 NP=4 NM=4
.param LPHASE=1.466666666666667n CFLY={4*10u+2*4.7u+2*2.2u}
.param COUT={8*220u+32*47u+64*22u} RLOAD={VOUT_REF*VOUT_REF/POUT_MODULE}
.param NEG_FRAC=.02 I_NEG={NEG_FRAC*I_GATE_OFF}
.param CH={GS61008T_COTR_0_50V} CL={2*GS61008T_COTR_0_50V}
.param RHS={GS61008T_RDS_TYP_25C} RLS={GS61008T_RDS_TYP_25C/2}
.param TENABLE=10n VGATE=5 RLDAMP=1u
.step param I_GATE_OFF list .1 .25 .5 1 2 5 10

* Powered-rail startup boundary: 48 V exists before controller enable. Device
* Coss is allowed to assume its natural OFF-state voltage at the DC solution;
* flying/output capacitors and inductors remain zero-start targets.
VRAIL vin 0 {VIN}
CCO out 0 {COUT} ic=0
RLOAD_MAIN out 0 {RLOAD}
XMOD vin out 0 gh1_cmd gl1_cmd SCB4P_P24_SWEEP

.machine 1p
.state ENERGY 0
.state HS_OFF_COMMUTATE_LOW 1
.state LOW_FREEWHEEL_TO_ZERO 2
.state LOW_BUILD_NEGATIVE 3
.state COMMUTATE_HIGH_TO_ZVS 4
.state BLOCK_P24_HANDOFF_UNKNOWN 5
.rule ENERGY HS_OFF_COMMUTATE_LOW time>=TENABLE & I(XMOD:L1)>=I_GATE_OFF
.rule HS_OFF_COMMUTATE_LOW LOW_FREEWHEEL_TO_ZERO V(xmod:x1)<=0
.rule LOW_FREEWHEEL_TO_ZERO LOW_BUILD_NEGATIVE I(XMOD:L1)<=0
.rule LOW_BUILD_NEGATIVE COMMUTATE_HIGH_TO_ZVS I(XMOD:L1)<=-I_NEG
.rule COMMUTATE_HIGH_TO_ZVS BLOCK_P24_HANDOFF_UNKNOWN V(vin,xmod:a1)<=0
.output (state_mon) state
.output (gh1_cmd) VGATE*(state==ENERGY)*(time>=TENABLE)
.output (gl1_cmd) VGATE*((state==LOW_FREEWHEEL_TO_ZERO)+(state==LOW_BUILD_NEGATIVE))
.endmachine

RSTATE state_mon 0 1k
RGH gh1_cmd 0 1k
RGL gl1_cmd 0 1k

.meas tran T_GATE_OFF WHEN V(state_mon)=.5 RISE=1
.meas tran I_AT_GATE_OFF FIND I(XMOD:L1) WHEN V(state_mon)=.5 RISE=1
.meas tran T_LOW_ZVS WHEN V(state_mon)=1.5 RISE=1
.meas tran I_AT_LOW_ZVS FIND I(XMOD:L1) WHEN V(state_mon)=1.5 RISE=1
.meas tran T_CURRENT_ZERO WHEN V(state_mon)=2.5 RISE=1
.meas tran T_NEG_TARGET WHEN V(state_mon)=3.5 RISE=1
.meas tran T_HIGH_ZVS WHEN V(state_mon)=4.5 RISE=1
.meas tran I_MAX MAX I(XMOD:L1) FROM 0 TO 5u
.meas tran I_MIN MIN I(XMOD:L1) FROM 0 TO 5u
.meas tran STATE_FINAL FIND V(state_mon) AT 5u
.meas tran VOUT_FINAL FIND V(out) AT 5u
.meas tran VC1_FINAL FIND V(xmod:a1,xmod:x1) AT 5u

.options plotwinsize=0 reltol=1e-5 abstol=1e-9 chgtol=1e-16 solver=alt cshunt=1e-15
.save V(state_mon) V(out) V(xmod:a1) V(xmod:x1) V(vin,xmod:a1) V(xmod:a1,xmod:x1) I(XMOD:L1)
.tran 0 5u 0 1n

.subckt SCB4P_P24_SWEEP vin out g gh1_in gl1_in
BGH1 gh1 g V=V(gh1_in,g)
BGL1 gl1 g V=V(gl1_in,g)
VGL2 gl2 g {VGATE}
VGH2 gh2 g 0
VGH3 gh3 g 0
VGH4 gh4 g 0
VGL3 gl3 g 0
VGL4 gl4 g 0

SH1 vin a1 gh1 g SWH
CH1 vin a1 {CH} ic=0
CS1 a1 x1 {CFLY} ic=0
CL1 x1 g {CL} ic=0
SL1 x1 g gl1 g SWL
L1 x1 out {LPHASE} Rser={RLDAMP} ic=0
SH2 a1 a2 gh2 g SWH
CS2 a2 x2 {CFLY} ic=0
SL2 x2 g gl2 g SWL
L2 x2 out {LPHASE} Rser={RLDAMP} ic=0
SH3 a2 a3 gh3 g SWH
CS3 a3 x3 {CFLY} ic=0
SL3 x3 g gl3 g SWL
L3 x3 out {LPHASE} Rser={RLDAMP} ic=0
SH4 a3 x4 gh4 g SWH
SL4 x4 g gl4 g SWL
L4 x4 out {LPHASE} Rser={RLDAMP} ic=0

RNUM_A1 a1 g 1Meg
RNUM_X1 x1 g 1Meg
RNUM_A2 a2 g 1Meg
RNUM_X2 x2 g 1Meg
RNUM_A3 a3 g 1Meg
RNUM_X3 x3 g 1Meg
RNUM_X4 x4 g 1Meg
.model SWH SW(Ron={RHS} Roff=1T Vt=2.5 Vh=0)
.model SWL SW(Ron={RLS} Roff=1T Vt=2.5 Vh=0)
.ends SCB4P_P24_SWEEP
.end
