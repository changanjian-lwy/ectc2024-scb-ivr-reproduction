* R04D1B - t1 capacitance-commutation sensitivity, not a fitted P24 value
* INCOMING STATE: measured R04D0 endpoint; QH1 is OFF and QL1 remains OFF.
* P24 mechanism: positive iL1 charges QH1 output capacitance and discharges
* QL1 output capacitance. P25 supplies symbolic CH1/CL1 treatment.
*
* UNSOURCED NUMERIC SLOT
* P24/P25 do not publish CH1/CL1. CCOMM is therefore swept at 0.1/1/10 nF
* only to test direction and timing sensitivity around P24's "nano-farad"
* statement. No point is the adopted 2024 design and no ZVS hardware claim is
* allowed. CH1=CL1 is a labelled symmetry assumption for this sensitivity run.

.param VIN=48 NP=4 NM=1 VO=1 FSW=5Meg T={1/FSW}
.param LPHASE=1.4666667n CFLY=53.8u
.param IL1_T1=124.932723999 VC1_T1=36.0193109995 IL2_T1=-11.3505529996
.param VX1_T1={VIN-VC1_T1}
.step param CCOMM list 0.1n 1n 10n

VIN_SRC vin 0 {VIN}
VOUT out 0 {VO}
VGH1 gh1 0 0
VGL1 gl1 0 0
VGL2 gl2 0 5
VGH2 gh2 0 0

SH1 vin a1 gh1 0 SWI
CH1 vin a1 {CCOMM} IC=0
CF1 a1 x1 {CFLY} IC={VC1_T1}
CL1 x1 0 {CCOMM} IC={VX1_T1}
SL1 x1 0 gl1 0 SWI
L1 x1 out {LPHASE} Rser=1u IC={IL1_T1}

SH2 a1 a2 gh2 0 SWI
CF2 a2 x2 {CFLY} IC=24
SL2 x2 0 gl2 0 SWI
L2 x2 out {LPHASE} Rser=1u IC={IL2_T1}

.model SWI SW(Ron=1u Roff=1T Vt=2.5 Vh=0)

.meas tran T_LOW_VDS_ZERO WHEN V(x1)=0 FALL=1
.meas tran IL1_AT_LOW_ZERO FIND I(L1) WHEN V(x1)=0 FALL=1
.meas tran HIGH_VDS_AT_LOW_ZERO FIND V(vin,a1) WHEN V(x1)=0 FALL=1
.meas tran VC1_AT_LOW_ZERO FIND V(a1,x1) WHEN V(x1)=0 FALL=1
.meas tran LOW_VDS_MIN MIN V(x1) FROM 0 TO 10n
.meas tran HIGH_VDS_MAX MAX V(vin,a1) FROM 0 TO 10n
.meas tran IL1_MIN MIN I(L1) FROM 0 TO 10n
.meas tran IL1_START FIND I(L1) AT 1p
.meas tran CCOMM_USED PARAM {CCOMM}
.meas tran NP_EXPLICIT PARAM {NP}
.meas tran NM_EXPLICIT PARAM {NM}

.options reltol=1e-7 abstol=1e-10 chgtol=1e-16
.save V(vin,a1) V(x1) I(L1) I(CH1) I(CL1)
.tran 0 10n 0 0.5p UIC
.end
