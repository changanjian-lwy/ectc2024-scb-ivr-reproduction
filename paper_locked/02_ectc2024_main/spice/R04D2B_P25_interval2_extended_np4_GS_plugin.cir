* R04D2B - P25 Mode 2 extended from nP=3 to the P24 nP=4 topology
* SEQUENCE: P25 branch. SH1 is OFF; SL2, SL3 and the nP=4 extension SL4 remain
* ON. The accepted interval ends when Vds(SL1)=0 and ideal event logic turns
* SL1 ON (P25 t2). No P24 current-zero t2 claim is made in this branch.
*
* DEVICE PLUG-IN
* P25 Table III: one GS61008T high side and two in parallel per low side.
* Official time-equivalent scalar: CH=385 pF, CL=770 pF. No external snubber,
* nonlinear Coss, numeric dead time or detector delay is included. Mode 2-prime
* is intentionally minimized by ideal zero-delay event logic.

.include ../../04_component_models/GS61008T_typical_params.lib

.param VIN=48 NP=4 NM=1 VO=1 FSW=5Meg
.param LPHASE=1.4666667n CFLY=53.8u
.param IL1_T1=124.932723999 VC1_T1=36.0193109995
.param IINACTIVE_T1=-11.3505529996 VX1_T1={VIN-VC1_T1}
.param NHS=1 NLS=2
.param CH={NHS*GS61008T_COTR_0_50V} CL={NLS*GS61008T_COTR_0_50V}
.param RHS={GS61008T_RDS_TYP_25C/NHS} RLS={GS61008T_RDS_TYP_25C/NLS}

VIN_SRC vin 0 {VIN}
VOUT out 0 {VO}
VGH1 gh1 0 0
VGH2 gh2 0 0
VGH3 gh3 0 0
VGH4 gh4 0 0
VGL2 gl2 0 5
VGL3 gl3 0 5
VGL4 gl4 0 5
RGL1 gl1 0 1k
RSTATE state_mon 0 1k

.machine 1p
.state P25_MODE2 0
.state P25_T2_SL1_ON 1
.rule P25_MODE2 P25_T2_SL1_ON V(x1)<0
.output (gl1) 5*(state==P25_T2_SL1_ON)
.output (state_mon) state
.endmachine

SH1 vin a1 gh1 0 SWH
CH1 vin a1 {CH} IC=0
CF1 a1 x1 {CFLY} IC={VC1_T1}
CL1 x1 0 {CL} IC={VX1_T1}
SL1 x1 0 gl1 0 SWL
L1 x1 out {LPHASE} Rser=1u IC={IL1_T1}

SH2 a1 a2 gh2 0 SWH
CF2 a2 x2 {CFLY} IC=24
SL2 x2 0 gl2 0 SWL
L2 x2 out {LPHASE} Rser=1u IC={IINACTIVE_T1}

SH3 a2 a3 gh3 0 SWH
CF3 a3 x3 {CFLY} IC=12
SL3 x3 0 gl3 0 SWL
L3 x3 out {LPHASE} Rser=1u IC={IINACTIVE_T1}

SH4 a3 x4 gh4 0 SWH
SL4 x4 0 gl4 0 SWL
L4 x4 out {LPHASE} Rser=1u IC={IINACTIVE_T1}

.model SWH SW(Ron={RHS} Roff=1T Vt=2.5 Vh=0)
.model SWL SW(Ron={RLS} Roff=1T Vt=2.5 Vh=0)

.meas tran P25_T2_LOW_ZVS WHEN V(x1)=0 FALL=1
.meas tran P25_IL1_AT_T2 FIND I(L1) WHEN V(x1)=0 FALL=1
.meas tran P25_IL2_AT_T2 FIND I(L2) WHEN V(x1)=0 FALL=1
.meas tran P25_IL3_AT_T2 FIND I(L3) WHEN V(x1)=0 FALL=1
.meas tran P25_IL4_AT_T2 FIND I(L4) WHEN V(x1)=0 FALL=1
.meas tran VGL1_MAX MAX V(gl1)
.meas tran CH_USED PARAM {CH}
.meas tran CL_USED PARAM {CL}
.meas tran NP_EXPLICIT PARAM {NP}
.meas tran NM_EXPLICIT PARAM {NM}

.options reltol=1e-7 abstol=1e-10 chgtol=1e-16
.save V(x1) V(vin,a1) I(L1) I(L2) I(L3) I(L4) V(gl1) V(state_mon)
.tran 0 3n 0 0.5p UIC
.end
