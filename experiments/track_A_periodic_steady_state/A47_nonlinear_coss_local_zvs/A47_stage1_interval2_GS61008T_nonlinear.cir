* A47 stage 1 - P24 interval 2, nonlinear GS61008T Coss(V) commutation cap
* PARENT: R04D2A_P24_interval2_to_IL1_zero_GS_plugin.cir. SINGLE CHANGED
* VARIABLE: CH1/CL1 constant-Co(tr) capacitors replaced with a nonlinear,
* digitized-and-fitted Coss(V) charge source (see A47 BOUNDARY.md). Ron
* (RHS/RLS) is unchanged from the GS61008T 1-HS/2-LS values.
* SEQUENCE: P24 only. At t1 QH1 is OFF; positive iL1 commutates the high/low
* output capacitances; QL1 is ideally commanded ON when its Vds reaches zero;
* the accepted interval ends when iL1 reaches zero (P24 t2).
*
* P24 MINIMAL GATE CONTEXT
* QS2 remains ON. Other low-side states are unspecified and omitted from this
* local two-phase subnetwork; omission is not asserted to mean OFF.
*
* DEVICE PLUG-IN, NOT P24 DEVICE EVIDENCE
* P25 Table III population (1 high-side, 2 parallel low-side GS61008T),
* Ron=3.5 mOhm low-side / 7 mOhm high-side, unchanged from R04D2A/A42.
* Commutation capacitance is now the digitized, fitted nonlinear Coss(V)
* curve from GS61008T_nonlinear_coss.lib, not a constant Co(tr) scalar.
* No external snubber, detector delay or dead time is included.

.include ../../../paper_locked/04_component_models/GS61008T_typical_params.lib
.include ../../../paper_locked/04_component_models/GS61008T_nonlinear_coss.lib

.param VIN=48 NP=4 NM=1 VO=1 FSW=5Meg
.param LPHASE=1.4666667n CFLY=53.8u
.param IL1_T1=124.932723999 VC1_T1=36.0193109995 IL2_T1=-11.3505529996
.param VX1_T1={VIN-VC1_T1}
* Ron frozen at the GS61008T 1-HS/2-LS literal divisors, independent of
* whichever library happens to define NHS/NLS (defensive, see header).
.param RHS={GS61008T_RDS_TYP_25C/1} RLS={GS61008T_RDS_TYP_25C/2}

VIN_SRC vin 0 {VIN}
VOUT out 0 {VO}
VGH1 gh1 0 0
VGL2 gl2 0 5
VGH2 gh2 0 0
RGL1 gl1 0 1k
RSTATE state_mon 0 1k

.machine 1p
.state P24_COMMUTATE 0
.state P24_QL1_ON 1
.rule P24_COMMUTATE P24_QL1_ON V(x1)<0
.output (gl1) 5*(state==P24_QL1_ON)
.output (state_mon) state
.endmachine

SH1 vin a1 gh1 0 SWH
* Split into a real linear floor capacitor (carries IC=, which is what
* LTspice's UIC transient start actually honors for a node's initial
* voltage -- a bare top-level .ic directive on a B-source-only node was
* NOT honored at t=0, confirmed empirically) plus a ddt() B-source
* carrying only the bounded nonlinear correction term. Mathematically
* identical to a single Q=CFLOOR*V+A*VKNEE*atan(V/VKNEE) source; see
* A47 BOUNDARY.md 'LTspice implementation note' for why this split (and
* method=gear below) was needed for convergence.
CH1LIN vin a1 {NHS_NL*GS61008T_NL_CFLOOR} IC=0
BCH1 vin a1 I=ddt(NHS_NL*GS61008T_NL_A*GS61008T_NL_VKNEE*atan(V(vin,a1)/GS61008T_NL_VKNEE))
CF1 a1 x1 {CFLY} IC={VC1_T1}
CL1LIN x1 0 {NLS_NL*GS61008T_NL_CFLOOR} IC={VX1_T1}
BCL1 x1 0 I=ddt(NLS_NL*GS61008T_NL_A*GS61008T_NL_VKNEE*atan(V(x1)/GS61008T_NL_VKNEE))
SL1 x1 0 gl1 0 SWL
L1 x1 out {LPHASE} Rser=1u IC={IL1_T1}

SH2 a1 a2 gh2 0 SWH
CF2 a2 x2 {CFLY} IC=24
SL2 x2 0 gl2 0 SWL
L2 x2 out {LPHASE} Rser=1u IC={IL2_T1}

.model SWH SW(Ron={RHS} Roff=1T Vt=2.5 Vh=0)
.model SWL SW(Ron={RLS} Roff=1T Vt=2.5 Vh=0)

.meas tran P24_T_LOW_ZVS WHEN V(x1)=0 FALL=1
.meas tran P24_IL1_AT_LOW_ZVS FIND I(L1) WHEN V(x1)=0 FALL=1
.meas tran P24_T2_IL1_ZERO WHEN I(L1)=0 FALL=1
.meas tran P24_A1_AT_IL1_ZERO FIND V(a1) WHEN I(L1)=0 FALL=1
.meas tran P24_X1_AT_IL1_ZERO FIND V(x1) WHEN I(L1)=0 FALL=1
.meas tran P24_C1_AT_IL1_ZERO FIND V(a1,x1) WHEN I(L1)=0 FALL=1
.meas tran P24_IL2_AT_IL1_ZERO FIND I(L2) WHEN I(L1)=0 FALL=1
.meas tran P24_INTERVAL2_DURATION PARAM P24_T2_IL1_ZERO
.meas tran P24_FREEWHEEL_DURATION PARAM P24_T2_IL1_ZERO-P24_T_LOW_ZVS
.meas tran VGL1_MAX MAX V(gl1)
.meas tran COSS_CFLOOR_USED PARAM {GS61008T_NL_CFLOOR}
.meas tran COSS_A_USED PARAM {GS61008T_NL_A}
.meas tran COSS_VKNEE_USED PARAM {GS61008T_NL_VKNEE}
.meas tran NP_EXPLICIT PARAM {NP}
.meas tran NM_EXPLICIT PARAM {NM}

* method=gear: the default trapezoidal integrator failed to converge
* (timestep collapsed to ~1e-17s) on this nonlinear-Coss(V) stiff
* capacitor-loop circuit; Gear's method converges normally. This is a
* solver-selection change only, not a circuit/physics change -- see
* A47 BOUNDARY.md 'LTspice implementation note'.
.options reltol=1e-7 abstol=1e-10 chgtol=1e-16 method=gear
.save V(x1) V(vin,a1) I(L1) I(L2) V(gl1) V(state_mon)
.tran 0 210n 0 1p UIC
.end
