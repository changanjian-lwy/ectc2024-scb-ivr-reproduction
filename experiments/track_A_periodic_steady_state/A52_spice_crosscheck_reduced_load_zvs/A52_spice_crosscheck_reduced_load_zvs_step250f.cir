* A52_spice_crosscheck_reduced_load_zvs_step250f
* A52 -- SPICE cross-check of A51's four-phase joint ZVS state.
* Seed state, topology values and EVERY commanded switching instant are
* generated by `build_full_netlist.py` from `solver_copy`'s own
* `commanded_pwm_mode` / `ZeroStartBoundary`; nothing below is hand-typed.
*
* Absolute solver time of this period's start (A51's own `period_start_s`,
* = BASE_PERIOD_INDEX*T + d/2)     : 2.3001075e-05 s
* Netlist time offset TOFFSET       : 2.3001075e-05 s
*   netlist time tau = t_absolute - TOFFSET, so `.tran` starts at tau=0,
*   which is the instant A51's period map starts from (phase 1 goes HIGH).
* Period T                          : 2e-07 s
* Ton                               : 1.6666666666666664e-08 s
* Dead time d                       : 2.15e-09 s
* Ron (UNIFORM, both sides, all four phases, BOUNDARY Section 2)
*                                   : 0.007 ohm
* CH_TOTAL / CL_TOTAL               : 3.85e-10 /
*                                     7.7e-10 F
* CFLY                              : 3e-06 F
* RLOAD = Vout^2/P at Section 1's ACTUAL delivered power
*   0.687944^2 / 89.9207 = 0.0052631590627742 ohm
* Maximum timestep                  : 2.5e-13 s
.param VG=5.0 VTH=2.5
.param RON=0.007
.param CH_TOTAL=3.85e-10
.param CL_TOTAL=7.7e-10
.param CFLY=3e-06
.param COUT=0.004672
.param RLOAD=0.0052631590627742
.param LPHASE=1.4666667e-09 RLSER=1e-06
.param LSRC=5e-09 RSRC=0.01
.param CDIV=0.0003 RDIVLEAK=1000000000.0
.param RDIODE_OFF=1000000000000.0
.param VIN=48.0

* ---------------- source path (constant 48 V, no ramp) ----------------
V_SRC src 0 {VIN}
R_SRC src src_r {RSRC}
L_PAR_IN src_r vin {LSRC} Rser=0 ic=3.4309784504693295

* ---------------- precharge divider (divider_enabled=True) -------------
C_DIV4 vin tap3 {CDIV}
R_DIV4 vin tap3 {RDIVLEAK}
C_DIV3 tap3 tap2 {CDIV}
R_DIV3 tap3 tap2 {RDIVLEAK}
C_DIV2 tap2 tap1 {CDIV}
R_DIV2 tap2 tap1 {RDIVLEAK}
C_DIV1 tap1 0 {CDIV}
R_DIV1 tap1 0 {RDIVLEAK}
* Precharge diodes, held OFF for the whole run: A51's `evaluate_period_map`
* is called throughout with diode_state=(False, False, False), which the
* descriptor renders as `diode_off_resistance_ohm`.
R_PD3 tap3 a1 {RDIODE_OFF}
R_PD2 tap2 a2 {RDIODE_OFF}
R_PD1 tap1 a3 {RDIODE_OFF}

* ---------------- four-phase series-capacitor ladder --------------------
* No reverse-conduction diode is instantiated anywhere: see this builder's
* own module docstring.  A51's model has none.
SH1 vin a1 gh1 0 SWU
CH1_TOTAL vin a1 {CH_TOTAL}
C1 a1 x1 {CFLY}
CL1_TOTAL x1 0 {CL_TOTAL}
SL1 x1 0 gl1 0 SWU
LIND1 x1 out {LPHASE} Rser={RLSER} ic=-5.202377626634099

SH2 a1 a2 gh2 0 SWU
CH2_TOTAL a1 a2 {CH_TOTAL}
C2 a2 x2 {CFLY}
CL2_TOTAL x2 0 {CL_TOTAL}
SL2 x2 0 gl2 0 SWU
LIND2 x2 out {LPHASE} Rser={RLSER} ic=3.07242026743103

SH3 a2 a3 gh3 0 SWU
CH3_TOTAL a2 a3 {CH_TOTAL}
C3 a3 x3 {CFLY}
CL3_TOTAL x3 0 {CL_TOTAL}
SL3 x3 0 gl3 0 SWU
LIND3 x3 out {LPHASE} Rser={RLSER} ic=30.358686656836504

SH4 a3 x4 gh4 0 SWU
CH4_TOTAL a3 x4 {CH_TOTAL}
CL4_TOTAL x4 0 {CL_TOTAL}
SL4 x4 0 gl4 0 SWU
LIND4 x4 out {LPHASE} Rser={RLSER} ic=67.36321312878287

C_OUT out 0 {COUT}
R_LOAD out 0 {RLOAD}

* Ron is UNIFORM for high and low side alike (BOUNDARY Section 2); A51's
* ZeroStartBoundary has a single scalar switch_on_resistance_ohm.
.model SWU SW(Ron={RON} Roff=1000000000000.0 Vt={VTH} Vh=0)

* ---------------- commanded schedule, one machine per phase -------------
* Each machine is the SAME HIGH -> DEADTIME -> LOW -> DEADTIME schedule
* `commanded_pwm_mode` emits, UNROLLED over this run so that every
* commanded instant is an exact `time>=` constant with no waveform,
* threshold or modular arithmetic anywhere.  Each dead-time window exits on
* `(natural V<=0 crossing) | (commanded window end)` -- whichever comes
* first -- which is `resolve_deadtime_window`'s own rule and the mechanism
* validated by this experiment's own pilot.

.machine 1p
.state P1_S0 0
.state P1_S1 1
.state P1_S2 2
.state P1_S3 3
.state P1_S4 4
.state P1_S5 5
.state P1_S6 6
.rule P1_S0 P1_S1 time>=1.451666666667e-08
.rule P1_S1 P1_S2 (V(x1)<=0) | (time>=1.666666666667e-08)
.rule P1_S2 P1_S3 time>=1.978500000000e-07
.rule P1_S3 P1_S4 (V(vin,a1)<=0) | (time>=2.000000000000e-07)
.rule P1_S4 P1_S5 time>=2.145166666667e-07
.rule P1_S5 P1_S6 (V(x1)<=0) | (time>=2.166666666667e-07)
.output (gh1) VG*((state==P1_S0)+(state==P1_S4))
.output (gl1) VG*((state==P1_S2)+(state==P1_S6))
.output (p1state) state
.endmachine

.machine 1p
.state P2_S0 0
.state P2_S1 1
.state P2_S2 2
.state P2_S3 3
.state P2_S4 4
.state P2_S5 5
.state P2_S6 6
.rule P2_S0 P2_S1 time>=4.785000000000e-08
.rule P2_S1 P2_S2 (V(a1,a2)<=0) | (time>=5.000000000000e-08)
.rule P2_S2 P2_S3 time>=6.451666666667e-08
.rule P2_S3 P2_S4 (V(x2)<=0) | (time>=6.666666666667e-08)
.rule P2_S4 P2_S5 time>=2.478500000000e-07
.rule P2_S5 P2_S6 (V(a1,a2)<=0) | (time>=2.500000000000e-07)
.output (gh2) VG*((state==P2_S2)+(state==P2_S6))
.output (gl2) VG*((state==P2_S0)+(state==P2_S4))
.output (p2state) state
.endmachine

.machine 1p
.state P3_S0 0
.state P3_S1 1
.state P3_S2 2
.state P3_S3 3
.state P3_S4 4
.rule P3_S0 P3_S1 time>=9.785000000000e-08
.rule P3_S1 P3_S2 (V(a2,a3)<=0) | (time>=1.000000000000e-07)
.rule P3_S2 P3_S3 time>=1.145166666667e-07
.rule P3_S3 P3_S4 (V(x3)<=0) | (time>=1.166666666667e-07)
.output (gh3) VG*((state==P3_S2))
.output (gl3) VG*((state==P3_S0)+(state==P3_S4))
.output (p3state) state
.endmachine

.machine 1p
.state P4_S0 0
.state P4_S1 1
.state P4_S2 2
.state P4_S3 3
.state P4_S4 4
.rule P4_S0 P4_S1 time>=1.478500000000e-07
.rule P4_S1 P4_S2 (V(a3,x4)<=0) | (time>=1.500000000000e-07)
.rule P4_S2 P4_S3 time>=1.645166666667e-07
.rule P4_S3 P4_S4 (V(x4)<=0) | (time>=1.666666666667e-07)
.output (gh4) VG*((state==P4_S2))
.output (gl4) VG*((state==P4_S0)+(state==P4_S4))
.output (p4state) state
.endmachine

R_GH1 gh1 0 1k
R_GH2 gh2 0 1k
R_GH3 gh3 0 1k
R_GH4 gh4 0 1k
R_GL1 gl1 0 1k
R_GL2 gl2 0 1k
R_GL3 gl3 0 1k
R_GL4 gl4 0 1k
R_PS1 p1state 0 1k
R_PS2 p2state 0 1k
R_PS3 p3state 0 1k
R_PS4 p4state 0 1k

* ---------------- measurements -----------------------------------------
* ---- phase 1 turn-on window [1.978500000000e-07, 2.000000000000e-07] s (netlist time)
.meas tran TON_P1 WHEN V(p1state)=3.5 RISE=1
.meas tran VDSON_P1 FIND V(vin,a1) WHEN V(p1state)=3.5 RISE=1
.meas tran ILON_P1 FIND I(LIND1) WHEN V(p1state)=3.5 RISE=1
.meas tran TXP1 WHEN V(vin,a1)=0 TD=1.978500000000e-07 FALL=1
.meas tran VDSENT_P1 FIND V(vin,a1) AT 1.978500000000e-07
.meas tran ILENT_P1 FIND I(LIND1) AT 1.978500000000e-07
.meas tran VDSEND_P1 FIND V(vin,a1) AT 1.999999990000e-07
.meas tran VDSMIN_P1 MIN V(vin,a1) FROM 1.978500000000e-07 TO 2.000000000000e-07
.meas tran IMAX_P1 MAX ABS(I(LIND1)) FROM 0 TO 2.500000000000e-07
* ---- phase 2 turn-on window [4.785000000000e-08, 5.000000000000e-08] s (netlist time)
.meas tran TON_P2 WHEN V(p2state)=1.5 RISE=1
.meas tran VDSON_P2 FIND V(a1,a2) WHEN V(p2state)=1.5 RISE=1
.meas tran ILON_P2 FIND I(LIND2) WHEN V(p2state)=1.5 RISE=1
.meas tran TXP2 WHEN V(a1,a2)=0 TD=4.785000000000e-08 FALL=1
.meas tran VDSENT_P2 FIND V(a1,a2) AT 4.785000000000e-08
.meas tran ILENT_P2 FIND I(LIND2) AT 4.785000000000e-08
.meas tran VDSEND_P2 FIND V(a1,a2) AT 4.999999900000e-08
.meas tran VDSMIN_P2 MIN V(a1,a2) FROM 4.785000000000e-08 TO 5.000000000000e-08
.meas tran IMAX_P2 MAX ABS(I(LIND2)) FROM 0 TO 2.500000000000e-07
* ---- phase 3 turn-on window [9.785000000000e-08, 1.000000000000e-07] s (netlist time)
.meas tran TON_P3 WHEN V(p3state)=1.5 RISE=1
.meas tran VDSON_P3 FIND V(a2,a3) WHEN V(p3state)=1.5 RISE=1
.meas tran ILON_P3 FIND I(LIND3) WHEN V(p3state)=1.5 RISE=1
.meas tran TXP3 WHEN V(a2,a3)=0 TD=9.785000000000e-08 FALL=1
.meas tran VDSENT_P3 FIND V(a2,a3) AT 9.785000000000e-08
.meas tran ILENT_P3 FIND I(LIND3) AT 9.785000000000e-08
.meas tran VDSEND_P3 FIND V(a2,a3) AT 9.999999900000e-08
.meas tran VDSMIN_P3 MIN V(a2,a3) FROM 9.785000000000e-08 TO 1.000000000000e-07
.meas tran IMAX_P3 MAX ABS(I(LIND3)) FROM 0 TO 2.500000000000e-07
* ---- phase 4 turn-on window [1.478500000000e-07, 1.500000000000e-07] s (netlist time)
.meas tran TON_P4 WHEN V(p4state)=1.5 RISE=1
.meas tran VDSON_P4 FIND V(a3,x4) WHEN V(p4state)=1.5 RISE=1
.meas tran ILON_P4 FIND I(LIND4) WHEN V(p4state)=1.5 RISE=1
.meas tran TXP4 WHEN V(a3,x4)=0 TD=1.478500000000e-07 FALL=1
.meas tran VDSENT_P4 FIND V(a3,x4) AT 1.478500000000e-07
.meas tran ILENT_P4 FIND I(LIND4) AT 1.478500000000e-07
.meas tran VDSEND_P4 FIND V(a3,x4) AT 1.499999990000e-07
.meas tran VDSMIN_P4 MIN V(a3,x4) FROM 1.478500000000e-07 TO 1.500000000000e-07
.meas tran IMAX_P4 MAX ABS(I(LIND4)) FROM 0 TO 2.500000000000e-07
* ---- periodicity: same commanded configuration, one period apart
.meas tran VC1_I FIND V(a1,x1) AT 2p
.meas tran VC1_F FIND V(a1,x1) AT 2.000020000000e-07
.meas tran DVC1 PARAM VC1_F-VC1_I
.meas tran VC2_I FIND V(a2,x2) AT 2p
.meas tran VC2_F FIND V(a2,x2) AT 2.000020000000e-07
.meas tran DVC2 PARAM VC2_F-VC2_I
.meas tran VC3_I FIND V(a3,x3) AT 2p
.meas tran VC3_F FIND V(a3,x3) AT 2.000020000000e-07
.meas tran DVC3 PARAM VC3_F-VC3_I
.meas tran VOUT_I FIND V(out) AT 2p
.meas tran VOUT_F FIND V(out) AT 2.000020000000e-07
.meas tran DVOUT PARAM VOUT_F-VOUT_I
.meas tran VA1_I FIND V(a1) AT 2p
.meas tran VA1_F FIND V(a1) AT 2.000020000000e-07
.meas tran DVA1 PARAM VA1_F-VA1_I
.meas tran VA2_I FIND V(a2) AT 2p
.meas tran VA2_F FIND V(a2) AT 2.000020000000e-07
.meas tran DVA2 PARAM VA2_F-VA2_I
.meas tran VA3_I FIND V(a3) AT 2p
.meas tran VA3_F FIND V(a3) AT 2.000020000000e-07
.meas tran DVA3 PARAM VA3_F-VA3_I
.meas tran VX1_I FIND V(x1) AT 2p
.meas tran VX1_F FIND V(x1) AT 2.000020000000e-07
.meas tran DVX1 PARAM VX1_F-VX1_I
.meas tran VX2_I FIND V(x2) AT 2p
.meas tran VX2_F FIND V(x2) AT 2.000020000000e-07
.meas tran DVX2 PARAM VX2_F-VX2_I
.meas tran VX3_I FIND V(x3) AT 2p
.meas tran VX3_F FIND V(x3) AT 2.000020000000e-07
.meas tran DVX3 PARAM VX3_F-VX3_I
.meas tran VX4_I FIND V(x4) AT 2p
.meas tran VX4_F FIND V(x4) AT 2.000020000000e-07
.meas tran DVX4 PARAM VX4_F-VX4_I
.meas tran VVIN_I FIND V(vin) AT 2p
.meas tran VVIN_F FIND V(vin) AT 2.000020000000e-07
.meas tran DVVIN PARAM VVIN_F-VVIN_I
.meas tran VSRCR_I FIND V(src_r) AT 2p
.meas tran VSRCR_F FIND V(src_r) AT 2.000020000000e-07
.meas tran DVSRCR PARAM VSRCR_F-VSRCR_I
.meas tran VTAP1_I FIND V(tap1) AT 2p
.meas tran VTAP1_F FIND V(tap1) AT 2.000020000000e-07
.meas tran DVTAP1 PARAM VTAP1_F-VTAP1_I
.meas tran VTAP2_I FIND V(tap2) AT 2p
.meas tran VTAP2_F FIND V(tap2) AT 2.000020000000e-07
.meas tran DVTAP2 PARAM VTAP2_F-VTAP2_I
.meas tran VTAP3_I FIND V(tap3) AT 2p
.meas tran VTAP3_F FIND V(tap3) AT 2.000020000000e-07
.meas tran DVTAP3 PARAM VTAP3_F-VTAP3_I
.meas tran IL1_I FIND I(LIND1) AT 2p
.meas tran IL1_F FIND I(LIND1) AT 2.000020000000e-07
.meas tran DIL1 PARAM IL1_F-IL1_I
.meas tran IL2_I FIND I(LIND2) AT 2p
.meas tran IL2_F FIND I(LIND2) AT 2.000020000000e-07
.meas tran DIL2 PARAM IL2_F-IL2_I
.meas tran IL3_I FIND I(LIND3) AT 2p
.meas tran IL3_F FIND I(LIND3) AT 2.000020000000e-07
.meas tran DIL3 PARAM IL3_F-IL3_I
.meas tran IL4_I FIND I(LIND4) AT 2p
.meas tran IL4_F FIND I(LIND4) AT 2.000020000000e-07
.meas tran DIL4 PARAM IL4_F-IL4_I
.meas tran ILPAR_I FIND I(L_PAR_IN) AT 2p
.meas tran ILPAR_F FIND I(L_PAR_IN) AT 2.000020000000e-07
.meas tran DILPAR PARAM ILPAR_F-ILPAR_I
* ---- fingerprint: the commanded rail must not move
.meas tran VSRC_MIN MIN V(src)
.meas tran VSRC_MAX MAX V(src)
.meas tran VOUT_AVG AVG V(out) FROM 0 TO 2.000000000000e-07
.meas tran PLOAD_AVG AVG V(out)*V(out)/5.263159062774e-03 FROM 0 TO 2.000000000000e-07

.options plotwinsize=0 reltol=1e-6 abstol=1e-9 vntol=1e-9 chgtol=1e-16
+ solver=alt cshunt=1e-15
.save V(src) V(src_r) V(vin) V(tap1) V(tap2) V(tap3) V(a1) V(a2) V(a3) V(x1) V(x2) V(x3) V(x4) V(out) V(gh1) V(gh2) V(gh3) V(gh4) V(gl1) V(gl2) V(gl3) V(gl4) V(p1state) V(p2state) V(p3state) V(p4state) I(LIND1) I(LIND2) I(LIND3) I(LIND4) I(L_PAR_IN)
.ic V(src_r)=47.96569022236729 V(vin)=47.969789939303524 V(tap3)=36.0 V(tap2)=24.0 V(tap1)=12.0 V(a1)=48.00677396673983 V(a2)=24.036209731129393 V(a3)=11.636445707833776 V(x1)=11.742411388577601 V(x2)=-0.02167367897568295 V(x3)=-0.21253311225322608 V(x4)=-0.4715756542261936 V(out)=0.6878908393606893
.tran 0 2.500000000000e-07 0 2.500000000000e-13 UIC
.end
