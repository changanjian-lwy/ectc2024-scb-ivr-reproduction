* A42 refinement - zero-snubber 7.7% P25-supplement row
* START EVENT: P24 t2, iL1=0. State values are chained from R04D2A.
* END EVENT: P24 t3, Vds(QH1)=0 and ideal event logic commands QH1 ON.
*
* P24 EXPLICIT CONTROL
* QL1 remains ON after iL1 zero. At 1%-2% negative peak current it turns OFF;
* reverse iL1 commutates the phase-1 output capacitances. This run uses the
* selected threshold-refinement row: 7.7% of 125 A.
*
* DEVICE PLUG-IN, NOT P24 DEVICE EVIDENCE
* P25 Table III population and GS61008T CO(TR) scalar are retained from R04D2.
* No snubber, nonlinear Coss, detector delay, gate delay or dead time is added.

.include ../../../../paper_locked/04_component_models/GS61008T_typical_params.lib
.include ../../../../paper_locked/04_component_models/GS61008T_commutation_capacitance.lib

.param VIN=48 NP=4 NM=1 VO=1 FSW=5Meg
.param LPHASE=1.4666667n IPEAK_P24=125 NEG_FRAC=0.0770 INEG={NEG_FRAC*IPEAK_P24}
.param VC1_T2=36.0193959392 VX1_T2=-9.6476751536u VA1_T2=36.0193862915
.param RHS={GS61008T_RDS_TYP_25C/NHS} RLS={GS61008T_RDS_TYP_25C/NLS}

VIN_SRC vin 0 {VIN}
VOUT out 0 {VO}
RSTATE state_mon 0 1k
RGH1 gh1 0 1k
RGL1 gl1 0 1k

.machine 1p
.state P24_QL1_NEGATIVE 0
.state P24_COMMUTATE_TO_HIGH 1
.state P24_QH1_ZVS_ON 2
.rule P24_QL1_NEGATIVE P24_COMMUTATE_TO_HIGH I(L1)<-INEG
.rule P24_COMMUTATE_TO_HIGH P24_QH1_ZVS_ON V(vin,a1)<0
.output (gl1) 5*(state==P24_QL1_NEGATIVE)
.output (gh1) 5*(state==P24_QH1_ZVS_ON)
.output (state_mon) state
.endmachine

SH1 vin a1 gh1 0 SWH
CH1 vin a1 {CH_TOTAL} IC={VIN-VA1_T2}
CF1 a1 x1 53.8u IC={VC1_T2}
CL1 x1 0 {CL_TOTAL} IC={VX1_T2}
SL1 x1 0 gl1 0 SWL
L1 x1 out {LPHASE} Rser=1u IC=0

.model SWH SW(Ron={RHS} Roff=1T Vt=2.5 Vh=0)
.model SWL SW(Ron={RLS} Roff=1T Vt=2.5 Vh=0)

.meas tran P24_T_QL1_OFF WHEN I(L1)=-INEG FALL=1
.meas tran P24_IL1_AT_QL1_OFF FIND I(L1) WHEN I(L1)=-INEG FALL=1
.meas tran P24_T3_HIGH_VDS_ZERO WHEN V(vin,a1)=0 FALL=1
.meas tran P24_IL1_AT_T3 FIND I(L1) WHEN V(vin,a1)=0 FALL=1
.meas tran P24_COMMUTATION_DURATION PARAM P24_T3_HIGH_VDS_ZERO-P24_T_QL1_OFF
.meas tran P24_VDS_HS_MIN MIN V(vin,a1)
.meas tran P24_VDS_HS_MIN_AFTER_2NS MIN V(vin,a1) FROM=2n TO=50n
.meas tran P24_VDS_HS_END FIND V(vin,a1) AT=50n
.meas tran P24_VDS_LS_MAX MAX V(x1)
.meas tran P24_NEGATIVE_TARGET PARAM {INEG}
.meas tran NP_EXPLICIT PARAM {NP}
.meas tran NM_EXPLICIT PARAM {NM}

.options reltol=1e-7 abstol=1e-10 chgtol=1e-16
.save V(x1) V(vin,a1) I(L1) V(gl1) V(gh1) V(state_mon)
.tran 0 50n 0 0.5p UIC
.end
