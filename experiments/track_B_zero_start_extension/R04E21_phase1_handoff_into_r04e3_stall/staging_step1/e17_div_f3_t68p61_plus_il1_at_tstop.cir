* R04E21 STEP-1 COPY of R04E17's own e17_div_f3_t68p61.cir -- IDENTICAL to that file except ONE line added below (IL1_AT_TSTOP .meas); see R04E21's own BOUNDARY.md Section 2. R04E17's own original file is unmodified.
* R04E17 - factorial isolation of "divider removed" vs. "Vin ramped"
* (e17_div_f3_t68p61)
* PARENT: R04E16's e16_g1_f3_t68p61.cir (experiments/track_B_zero_
* start_extension/R04E16_roberts_softstart_fixed_timing/cases/
* e16_g1_f3_t68p61.cir), itself derived from R03A (paper_locked/
* 02_ectc2024_main/spice/R03A_passive_precharge_to_fixed_pwm_
* takeover.cir) -- four-phase power stage, TSTART=0 fixed-timing gate
* B-sources, LPHASE=1.4666667n, CFLY=3u, true-zero-energy IC,
* solver=alt cshunt=1e-15 plotwinsize=0/TMAX=50p all copied unchanged.
* CHANGED relative to e16_g1_f3_t68p61: R03A's own passive-divider-
* plus-diode precharge network (CIN1-4/RLEAK1-4/DPC1-3, model DPRE) is
* ADDED BACK, wired exactly as R03A itself wires it into the SAME real
* a1/a2/a3 power-stage nodes, with CDIV=300u (R04E15's own corrected
* best-point value at this project's Cfly=3u, NOT R03A's own 1.076m,
* which was sized for the old cross-topology-suspect Cfly=53.8u).
* Tramp=68.61us matches e16_g1_f3_t68p61 exactly (slow-ramp, 30x-margin
* cell of the 2x2). This is the "Divider PRESENT / slow ramp" cell of
* R04E17's 2x2 factorial design; see BOUNDARY.md Sections 2-3 for the
* full design and provenance of every changed value.
* UNCHANGED from e16_g1_f3_t68p61: everything else -- power-stage
* topology, COUT, RLOAD formula, ideal SWI switch, RLDAMP,
* true-zero-energy IC (UIC), TMAX=50p, IPEC2018 Table II source
* parasitics LPAR/RPAR, solver=alt/cshunt=1e-15/plotwinsize=0.
* Cfly=3 uF, Tramp=68.61 us, Cdiv=300 uF, Tstop=Tramp+300us.

.param VIN=48 VOUT=1 POUT=250 NP=4 FSW=5Meg T={1/FSW}
.param D={NP*VOUT/VIN} TON={D*T} LPHASE=1.4666667n
.param CFLY=3.000000e-06 COUT=4.672m RLOAD={VOUT*VOUT/POUT}
.param TRAMP=6.861000e-05 TSTART=0 TSTOP={TRAMP+300u}
.param LPAR=5n RPAR=10m RON=1u ROFF=1T VGATE=5 RLDAMP=1u
.param CDIV=300u

VSTEP src 0 PWL(0 0 {TRAMP} {VIN} {TSTOP} {VIN})
RPAR_IN src src_r {RPAR}
LPAR_IN src_r vin {LPAR}

* R03A's own passive divider/precharge-diode network, ADDED BACK per
* BOUNDARY.md Sections 2-3 -- wiring copied verbatim from R03A
* (paper_locked/02_ectc2024_main/spice/
* R03A_passive_precharge_to_fixed_pwm_takeover.cir), only CDIV changed
* (300u here, was 1.076m in R03A, sized for the old Cfly=53.8u). Feeds
* the SAME real a1/a2/a3 power-stage nodes the four-phase stage below
* already uses; no new topology invented.
CIN1 vin tap3 {CDIV}
CIN2 tap3 tap2 {CDIV}
CIN3 tap2 tap1 {CDIV}
CIN4 tap1 0 {CDIV}
RLEAK1 vin tap3 1G
RLEAK2 tap3 tap2 1G
RLEAK3 tap2 tap1 1G
RLEAK4 tap1 0 1G
DPC1 tap3 a1 DPRE
DPC2 tap2 a2 DPRE
DPC3 tap1 a3 DPRE

* Gate-generation formulas copied unchanged from R03A/e16_g1_f3_t68p61
* except TSTART=0 (PWM active for all time>=0, not delayed to 150us
* after Vin settles).
BH1 gh1 0 V=if(time>=TSTART & mod(time-TSTART+T,T)<TON,VGATE,0)
BL1 gl1 0 V=if(time<TSTART | mod(time-TSTART+T,T)>=TON,VGATE,0)
BH2 gh2 0 V=if(time>=TSTART & mod(time-TSTART+T-T/4,T)<TON,VGATE,0)
BL2 gl2 0 V=if(time<TSTART | mod(time-TSTART+T-T/4,T)>=TON,VGATE,0)
BH3 gh3 0 V=if(time>=TSTART & mod(time-TSTART+T-T/2,T)<TON,VGATE,0)
BL3 gl3 0 V=if(time<TSTART | mod(time-TSTART+T-T/2,T)>=TON,VGATE,0)
BH4 gh4 0 V=if(time>=TSTART & mod(time-TSTART+T-3*T/4,T)<TON,VGATE,0)
BL4 gl4 0 V=if(time<TSTART | mod(time-TSTART+T-3*T/4,T)>=TON,VGATE,0)

SH1 vin a1 gh1 0 SWI
CF1 a1 x1 {CFLY}
SL1 x1 0 gl1 0 SWI
L1 x1 out {LPHASE} Rser={RLDAMP}
SH2 a1 a2 gh2 0 SWI
CF2 a2 x2 {CFLY}
SL2 x2 0 gl2 0 SWI
L2 x2 out {LPHASE} Rser={RLDAMP}
SH3 a2 a3 gh3 0 SWI
CF3 a3 x3 {CFLY}
SL3 x3 0 gl3 0 SWI
L3 x3 out {LPHASE} Rser={RLDAMP}
SH4 a3 x4 gh4 0 SWI
SL4 x4 0 gl4 0 SWI
L4 x4 out {LPHASE} Rser={RLDAMP}

CCO out 0 {COUT}
RLOAD_MAIN out 0 {RLOAD}
.model SWI SW(Ron={RON} Roff={ROFF} Vt=2.5 Vh=0)
.model DPRE D(Ron=1m Roff=1T Vfwd=0)

.meas tran VC1_INIT FIND V(a1,x1) AT 1n
.meas tran VC2_INIT FIND V(a2,x2) AT 1n
.meas tran VC3_INIT FIND V(a3,x3) AT 1n
.meas tran VC1_AT_TRAMP FIND V(a1,x1) AT {TRAMP}
.meas tran VC2_AT_TRAMP FIND V(a2,x2) AT {TRAMP}
.meas tran VC3_AT_TRAMP FIND V(a3,x3) AT {TRAMP}
.meas tran VOUT_AT_TRAMP FIND V(out) AT {TRAMP}
.meas tran VC1_FINAL FIND V(a1,x1) AT {TSTOP-1n}
.meas tran VC2_FINAL FIND V(a2,x2) AT {TSTOP-1n}
.meas tran VC3_FINAL FIND V(a3,x3) AT {TSTOP-1n}
.meas tran VOUT_FINAL FIND V(out) AT {TSTOP-1n}
.meas tran VOUT_PK MAX V(out) FROM 0 TO {TSTOP}
.meas tran VOUT_MIN MIN V(out) FROM 0 TO {TSTOP}
.meas tran VOUT_OVERSHOOT PARAM (VOUT_PK-VOUT)/VOUT
.meas tran IIN_PK MAX -I(VSTEP) FROM 0 TO {TSTOP}
.meas tran IL1_MIN MIN I(L1) FROM 0 TO {TSTOP}
.meas tran IL1_MAX MAX I(L1) FROM 0 TO {TSTOP}
.meas tran IL2_MIN MIN I(L2) FROM 0 TO {TSTOP}
.meas tran IL2_MAX MAX I(L2) FROM 0 TO {TSTOP}
.meas tran IL3_MIN MIN I(L3) FROM 0 TO {TSTOP}
.meas tran IL3_MAX MAX I(L3) FROM 0 TO {TSTOP}
.meas tran IL4_MIN MIN I(L4) FROM 0 TO {TSTOP}
.meas tran IL4_MAX MAX I(L4) FROM 0 TO {TSTOP}
.meas tran IL1_AT_TSTOP FIND I(L1) AT 368.61u
.meas tran VOUT_ERR PARAM abs(VOUT_FINAL-1)/1
.meas tran VC1_ERR PARAM abs(VC1_FINAL-36)/36
.meas tran VC2_ERR PARAM abs(VC2_FINAL-24)/24
.meas tran VC3_ERR PARAM abs(VC3_FINAL-12)/12
.meas tran LADDER_ERR PARAM VC1_ERR+VC2_ERR+VC3_ERR

.options plotwinsize=0 reltol=1e-5 abstol=1e-9 chgtol=1e-16 solver=alt cshunt=1e-15
.save V(vin) V(out) V(a1,x1) V(a2,x2) V(a3,x3) I(VSTEP) I(L1) I(L2) I(L3) I(L4)
.tran 0 {TSTOP} 0 50p UIC
.end
