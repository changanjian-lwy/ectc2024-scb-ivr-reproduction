* R04E15 - fine-grid refinement of R04E14's passive-precharge PASS cells
* (e15_c500_t100_f0p6)
* PARENT: R04E14 (byte-level-faithful copy of R02B's own circuit body):
* four equal input-divider capacitors, LPAR=5nH/RPAR=10mOhm source
* parasitics (IPEC 2018 Table II), three ideal precharge diodes
* (Ron=1m Roff=1T Vfwd=0), flying-capacitor lower terminals tied to the
* module reference (R02A's own "all-low-side-on precharge state"
* approximation), true-zero-energy initial conditions (UIC, no IC
* statements), no PWM/switches/load -- unchanged from R02A/R02B/R04E14.
* NO mechanism, topology, or parameter-model change relative to R04E14 --
* only this cell's own (CDIV, TRAMP, CFLY) point changes, per BOUNDARY.md
* Section 3's Grid A/B fine-grid refinement of R04E14's own coarse grid.
* CDIV=500 uF, TRAMP=100 us, CFLY=0.6 uF.

.param VIN=48 CFLY=6.000000e-07 CDIV=5.000000e-04 TRAMP=1.000000e-04 LPAR=5n RPAR=10m RLEAK=1G

VSTEP src 0 PWL(0 0 {TRAMP} {VIN} 500u {VIN})
RPAR_IN src src_r {RPAR}
LPAR_IN src_r vin {LPAR}

CIN1 vin tap3 {CDIV}
CIN2 tap3 tap2 {CDIV}
CIN3 tap2 tap1 {CDIV}
CIN4 tap1 0 {CDIV}
RLEAK1 vin tap3 {RLEAK}
RLEAK2 tap3 tap2 {RLEAK}
RLEAK3 tap2 tap1 {RLEAK}
RLEAK4 tap1 0 {RLEAK}

DPC1 tap3 vc1 DPRE
DPC2 tap2 vc2 DPRE
DPC3 tap1 vc3 DPRE
CF1 vc1 0 {CFLY}
CF2 vc2 0 {CFLY}
CF3 vc3 0 {CFLY}
.model DPRE D(Ron=1m Roff=1T Vfwd=0)

.meas tran VC1_FINAL AVG V(vc1) FROM 490u TO 500u
.meas tran VC2_FINAL AVG V(vc2) FROM 490u TO 500u
.meas tran VC3_FINAL AVG V(vc3) FROM 490u TO 500u
.meas tran RATIO21 PARAM VC2_FINAL/VC1_FINAL
.meas tran RATIO31 PARAM VC3_FINAL/VC1_FINAL
.meas tran LADDER_ERR PARAM abs(VC1_FINAL-36)/36+abs(VC2_FINAL-24)/24+abs(VC3_FINAL-12)/12
.meas tran IIN_PK MAX -I(VSTEP) FROM 0 TO 500u
.meas tran ID1_PK MAX I(DPC1) FROM 0 TO 500u
.meas tran ID2_PK MAX I(DPC2) FROM 0 TO 500u
.meas tran ID3_PK MAX I(DPC3) FROM 0 TO 500u

.options reltol=1e-5 abstol=1e-10 chgtol=1e-16
.save V(vin) V(vc1) V(vc2) V(vc3) I(VSTEP) I(DPC1) I(DPC2) I(DPC3)
.tran 0 500u 0 10n UIC
.end
