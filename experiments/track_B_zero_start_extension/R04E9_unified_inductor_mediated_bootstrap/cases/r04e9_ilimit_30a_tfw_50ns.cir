* R04E9 - unified inductor-mediated four-phase bootstrap (r04e9_ilimit_30a_tfw_50ns)
* SENSITIVITY CASE: I_LIMIT=30 A, T_FREEWHEEL_MAX=50 ns.
* SYNTHESIS of R03D (duty-ramp Vout bootstrap goal) + R04E3/R04E4/R04E5
* (event-driven, latched, current-limited .machine skeleton) + the
* rotate-and-monitor CONCEPT from R04E6/R04E7/R04E8 -- but using P24's OWN
* Interval-1 inductor-mediated charging path for every phase, NOT
* R04E6/E7/E8's borrowed switch-only EPE2019 mechanism. See
* build_b05_r04e9_unified_inductor_mediated_bootstrap.py module docstring
* and BOUNDARY.md for full parentage.
* Full four-phase P24 power stage, all four phases actively commanded by
* the machine (not one held statically, unlike R04E3/R04E5/R04E6-E8).
* True zero initial energy on every capacitor and inductor (ic=0, UIC).
* CFLY=3 uF (R04E8's own corrected middle value). COUT=4.672 mF
* (EPE2019 cross-topology candidate, NOT corrected here -- see BOUNDARY.md).
* TSTOP=3 us / TMAX=50 ps: pilot-confirmed converged
* window (see module docstring) -- fixed across the whole grid, not swept.
* SCOPE: bootstrap-only. Does NOT build or test handoff into the existing
* strict steady-state controller; only measures whether/when the handoff
* CONDITION is reached.

.include "../../../../paper_locked/04_component_models/GS61008T_typical_params.lib"
.param VIN=48 VOUT_REF=1 POUT_MODULE=250 NP=4 NM=4
.param LPHASE=1.466666667e-09 CFLY=3.000000e-06
.param COUT={8*220u+32*47u+64*22u} RLOAD={VOUT_REF*VOUT_REF/POUT_MODULE}
.param CH={GS61008T_COTR_0_50V} CL={2*GS61008T_COTR_0_50V}
.param RHS={GS61008T_RDS_TYP_25C} RLS={GS61008T_RDS_TYP_25C/2}
.param RLDAMP=1u VGATE=5

.param I_LIMIT=30
.param T_FREEWHEEL_MAX=5.000000e-08
* Elapsed-freewheel-time timer components (NUMERICAL_IDEALIZATION, no
* physical counterpart), same TIMER_C/TIMER_RESET_RON values R04E5 used
* for its own analogous elapsed-on-time timer.
.param TIMER_C=1p TIMER_RESET_RON=5

* Handoff-condition monitor (measurement only -- this experiment does NOT
* build or exercise the actual handoff/steady-state chain, per BOUNDARY.md).
.param VOUT_LO=0.950000 VOUT_HI=1.050000
.param VC1_LO=35.280000 VC1_HI=36.720000
.param VC2_LO=23.520000 VC2_HI=24.480000
.param VC3_LO=11.760000 VC3_HI=12.240000

VRAIL vin 0 {VIN}
CCO out 0 {COUT} ic=0
RLOAD_MAIN out 0 {RLOAD}
XMOD vin out 0 gh1_cmd gl1_cmd gh2_cmd gl2_cmd gh3_cmd gl3_cmd gh4_cmd gl4_cmd SCB4P_P24_R04E9

BVC1 vc1_mon 0 V=V(xmod:a1,xmod:x1)
BVC2 vc2_mon 0 V=V(xmod:a2,xmod:x2)
BVC3 vc3_mon 0 V=V(xmod:a3,xmod:x3)
RVC1 vc1_mon 0 1k
RVC2 vc2_mon 0 1k
RVC3 vc3_mon 0 1k

* Per-state elapsed-time freewheel timer (NUMERICAL_IDEALIZATION, no
* physical counterpart): charges (1 pA into 1 pF => V(timer) numerically
* equals elapsed time in seconds) only while the machine is in ANY
* freewheel state (FREE1/FREE2/FREE3/FREE4); reset through a low-Ron
* switch the instant it enters ANY charge state. Only one state is ever
* active at a time, so one shared timer serves all four phases -- same
* pattern as R04E5's ton_timer, with the charge/reset roles swapped
* (R04E5 timed elapsed ON-time; this experiment times elapsed FREEWHEEL
* time) and the A48 "event OR timeout, whichever first" idea applied per
* state instead of as a single global fixed delay.
CTIMER timer 0 {TIMER_C} ic=0
* NOTE: the B-source current coefficient is NEGATIVE (-1p), not +1p, even
* though the intent is to charge V(timer) UPWARD. Verified directly (not
* assumed): with +1p, V(timer) counted DOWNWARD (e.g. -9.42e-8 V at
* t=100 ns), because this simulator's B-source current convention for
* "Bxxx n+ n- I=expr" sources current OUT of n+ (the first node) for a
* positive expr -- the opposite of the naive expectation. With -1p,
* V(timer) counts upward exactly as intended (confirmed: T_FREEWHEEL_MAX=
* 50 ns now fires the FREE1->CHARGE2 transition at t=52.27 ns, matching
* the commanded 50 ns to within the same small overshoot margin R04E3/
* R04E4 already documented for their own current-limit turn-off event).
BTIMER_CHG timer 0 I=-1p*((V(state_mon)>0.5)&(V(state_mon)<1.5)|(V(state_mon)>2.5)&(V(state_mon)<3.5)|(V(state_mon)>4.5)&(V(state_mon)<5.5)|(V(state_mon)>6.5)&(V(state_mon)<7.5))
BRESET_GATE reset_gate 0 V=5*((V(state_mon)<0.5)|(V(state_mon)>1.5)&(V(state_mon)<2.5)|(V(state_mon)>3.5)&(V(state_mon)<4.5)|(V(state_mon)>5.5)&(V(state_mon)<6.5))
SRESET timer 0 reset_gate 0 SWRESET
.model SWRESET SW(Ron={TIMER_RESET_RON} Roff=1Meg Vt=2.5 Vh=0)

* Handoff-condition observer: high only while Vout and all three flying
* capacitor voltages simultaneously sit within their declared bands.
BHANDOFF handoff_flag 0 V=5*((V(out)>=VOUT_LO)&(V(out)<=VOUT_HI)&(V(vc1_mon)>=VC1_LO)&(V(vc1_mon)<=VC1_HI)&(V(vc2_mon)>=VC2_LO)&(V(vc2_mon)<=VC2_HI)&(V(vc3_mon)>=VC3_LO)&(V(vc3_mon)<=VC3_HI))
RHANDOFF handoff_flag 0 1k

* Unified event-driven, latched four-phase rotation machine. CHARGE_k
* exits at the R04E3/R04E4 current-limit rule (I(Lk)>=I_LIMIT); FREE_k
* exits at the earlier of the natural I(Lk)<=0 event or the
* T_FREEWHEEL_MAX timeout (A48-style event-OR-timeout).
.machine 1p
.state CHARGE1 0
.state FREE1 1
.state CHARGE2 2
.state FREE2 3
.state CHARGE3 4
.state FREE3 5
.state CHARGE4 6
.state FREE4 7
.rule CHARGE1 FREE1 I(XMOD:L1)>=I_LIMIT
.rule FREE1 CHARGE2 (I(XMOD:L1)<=0) | (V(timer)>=T_FREEWHEEL_MAX)
.rule CHARGE2 FREE2 I(XMOD:L2)>=I_LIMIT
.rule FREE2 CHARGE3 (I(XMOD:L2)<=0) | (V(timer)>=T_FREEWHEEL_MAX)
.rule CHARGE3 FREE3 I(XMOD:L3)>=I_LIMIT
.rule FREE3 CHARGE4 (I(XMOD:L3)<=0) | (V(timer)>=T_FREEWHEEL_MAX)
.rule CHARGE4 FREE4 I(XMOD:L4)>=I_LIMIT
.rule FREE4 CHARGE1 (I(XMOD:L4)<=0) | (V(timer)>=T_FREEWHEEL_MAX)
.output (gh1_cmd) VGATE*(state==CHARGE1)
.output (gl1_cmd) VGATE*(state==FREE1)
.output (gh2_cmd) VGATE*(state==CHARGE2)
.output (gl2_cmd) VGATE*(state==FREE2)
.output (gh3_cmd) VGATE*(state==CHARGE3)
.output (gl3_cmd) VGATE*(state==FREE3)
.output (gh4_cmd) VGATE*(state==CHARGE4)
.output (gl4_cmd) VGATE*(state==FREE4)
.output (state_mon) state
.output (rot_flag) VGATE*(state==FREE4)
.endmachine

RSTATE state_mon 0 1k
RROT rot_flag 0 1k
RGH1 gh1_cmd 0 1k
RGL1 gl1_cmd 0 1k
RGH2 gh2_cmd 0 1k
RGL2 gl2_cmd 0 1k
RGH3 gh3_cmd 0 1k
RGL3 gl3_cmd 0 1k
RGH4 gh4_cmd 0 1k
RGL4 gl4_cmd 0 1k

.meas tran STATE_FINAL FIND V(state_mon) AT 3.000000e-06
.meas tran VOUT_FINAL FIND V(out) AT 3.000000e-06
.meas tran VC1_FINAL FIND V(vc1_mon) AT 3.000000e-06
.meas tran VC2_FINAL FIND V(vc2_mon) AT 3.000000e-06
.meas tran VC3_FINAL FIND V(vc3_mon) AT 3.000000e-06
.meas tran T_HANDOFF WHEN V(handoff_flag)=2.5 RISE=1
.meas tran VOUT_AT_20PCT FIND V(out) AT 6.000000e-07
.meas tran VC1_AT_20PCT FIND V(vc1_mon) AT 6.000000e-07
.meas tran VC2_AT_20PCT FIND V(vc2_mon) AT 6.000000e-07
.meas tran VC3_AT_20PCT FIND V(vc3_mon) AT 6.000000e-07
.meas tran STATE_AT_20PCT FIND V(state_mon) AT 6.000000e-07
.meas tran VOUT_AT_40PCT FIND V(out) AT 1.200000e-06
.meas tran VC1_AT_40PCT FIND V(vc1_mon) AT 1.200000e-06
.meas tran VC2_AT_40PCT FIND V(vc2_mon) AT 1.200000e-06
.meas tran VC3_AT_40PCT FIND V(vc3_mon) AT 1.200000e-06
.meas tran STATE_AT_40PCT FIND V(state_mon) AT 1.200000e-06
.meas tran VOUT_AT_60PCT FIND V(out) AT 1.800000e-06
.meas tran VC1_AT_60PCT FIND V(vc1_mon) AT 1.800000e-06
.meas tran VC2_AT_60PCT FIND V(vc2_mon) AT 1.800000e-06
.meas tran VC3_AT_60PCT FIND V(vc3_mon) AT 1.800000e-06
.meas tran STATE_AT_60PCT FIND V(state_mon) AT 1.800000e-06
.meas tran VOUT_AT_80PCT FIND V(out) AT 2.400000e-06
.meas tran VC1_AT_80PCT FIND V(vc1_mon) AT 2.400000e-06
.meas tran VC2_AT_80PCT FIND V(vc2_mon) AT 2.400000e-06
.meas tran VC3_AT_80PCT FIND V(vc3_mon) AT 2.400000e-06
.meas tran STATE_AT_80PCT FIND V(state_mon) AT 2.400000e-06
.meas tran VOUT_AT_100PCT FIND V(out) AT 3.000000e-06
.meas tran VC1_AT_100PCT FIND V(vc1_mon) AT 3.000000e-06
.meas tran VC2_AT_100PCT FIND V(vc2_mon) AT 3.000000e-06
.meas tran VC3_AT_100PCT FIND V(vc3_mon) AT 3.000000e-06
.meas tran STATE_AT_100PCT FIND V(state_mon) AT 3.000000e-06
.meas tran IL1_MAX MAX I(XMOD:L1)
.meas tran IL1_MIN MIN I(XMOD:L1)
.meas tran IL2_MAX MAX I(XMOD:L2)
.meas tran IL2_MIN MIN I(XMOD:L2)
.meas tran IL3_MAX MAX I(XMOD:L3)
.meas tran IL3_MIN MIN I(XMOD:L3)
.meas tran IL4_MAX MAX I(XMOD:L4)
.meas tran IL4_MIN MIN I(XMOD:L4)
* NOTE: ICS1-3 windowed FROM 2n, not 0, excluding a sub-2ns t=0 ideal-
* switch/capacitor initial-condition numerical startup spike -- the same
* KIND of artifact R04E6 documented and excluded (its own bit-identical
* ~1.23e6 A "ICS1_MAX" across every swept cell, present regardless of the
* swept parameters, confirming it is a t=0 numerical transient, not a
* physical result). Diagnosed directly here, not assumed: an unwindowed
* check on the I_LIMIT=60A row found a 4548 A ICS1 spike whose .meas WHEN
* crossing landed at t=8.1e-20 s (state=CHARGE1, IL1~=0 A) -- i.e.
* genuinely at t=0, not a later physical event. A FROM 1n window (R04E8's
* own cutoff) left this one row's spike partly inside the window; FROM 2n
* removes it completely and gives a smoothly I_LIMIT-ordered result
* (0.298/0.361/0.577 A at I_LIMIT=10/30/60 A) confirmed stable from 2n
* through 50n windows (bit-identical at every wider cutoff tested).
.meas tran ICS1_MAX MAX I(XMOD:CS1) FROM 2n TO 3.000000e-06
.meas tran ICS1_MIN MIN I(XMOD:CS1) FROM 2n TO 3.000000e-06
.meas tran ICS2_MAX MAX I(XMOD:CS2) FROM 2n TO 3.000000e-06
.meas tran ICS2_MIN MIN I(XMOD:CS2) FROM 2n TO 3.000000e-06
.meas tran ICS3_MAX MAX I(XMOD:CS3) FROM 2n TO 3.000000e-06
.meas tran ICS3_MIN MIN I(XMOD:CS3) FROM 2n TO 3.000000e-06
.meas tran T_ROT1 WHEN V(rot_flag)=2.5 FALL=1
.meas tran VOUT_ROT1 FIND V(out) WHEN V(rot_flag)=2.5 FALL=1
.meas tran VC1_ROT1 FIND V(vc1_mon) WHEN V(rot_flag)=2.5 FALL=1
.meas tran VC2_ROT1 FIND V(vc2_mon) WHEN V(rot_flag)=2.5 FALL=1
.meas tran VC3_ROT1 FIND V(vc3_mon) WHEN V(rot_flag)=2.5 FALL=1
.meas tran T_ROT2 WHEN V(rot_flag)=2.5 FALL=2
.meas tran VOUT_ROT2 FIND V(out) WHEN V(rot_flag)=2.5 FALL=2
.meas tran VC1_ROT2 FIND V(vc1_mon) WHEN V(rot_flag)=2.5 FALL=2
.meas tran VC2_ROT2 FIND V(vc2_mon) WHEN V(rot_flag)=2.5 FALL=2
.meas tran VC3_ROT2 FIND V(vc3_mon) WHEN V(rot_flag)=2.5 FALL=2
.meas tran T_ROT3 WHEN V(rot_flag)=2.5 FALL=3
.meas tran VOUT_ROT3 FIND V(out) WHEN V(rot_flag)=2.5 FALL=3
.meas tran VC1_ROT3 FIND V(vc1_mon) WHEN V(rot_flag)=2.5 FALL=3
.meas tran VC2_ROT3 FIND V(vc2_mon) WHEN V(rot_flag)=2.5 FALL=3
.meas tran VC3_ROT3 FIND V(vc3_mon) WHEN V(rot_flag)=2.5 FALL=3
.meas tran T_ROT4 WHEN V(rot_flag)=2.5 FALL=4
.meas tran VOUT_ROT4 FIND V(out) WHEN V(rot_flag)=2.5 FALL=4
.meas tran VC1_ROT4 FIND V(vc1_mon) WHEN V(rot_flag)=2.5 FALL=4
.meas tran VC2_ROT4 FIND V(vc2_mon) WHEN V(rot_flag)=2.5 FALL=4
.meas tran VC3_ROT4 FIND V(vc3_mon) WHEN V(rot_flag)=2.5 FALL=4
.meas tran T_ROT5 WHEN V(rot_flag)=2.5 FALL=5
.meas tran VOUT_ROT5 FIND V(out) WHEN V(rot_flag)=2.5 FALL=5
.meas tran VC1_ROT5 FIND V(vc1_mon) WHEN V(rot_flag)=2.5 FALL=5
.meas tran VC2_ROT5 FIND V(vc2_mon) WHEN V(rot_flag)=2.5 FALL=5
.meas tran VC3_ROT5 FIND V(vc3_mon) WHEN V(rot_flag)=2.5 FALL=5
.meas tran T_ROT6 WHEN V(rot_flag)=2.5 FALL=6
.meas tran VOUT_ROT6 FIND V(out) WHEN V(rot_flag)=2.5 FALL=6
.meas tran VC1_ROT6 FIND V(vc1_mon) WHEN V(rot_flag)=2.5 FALL=6
.meas tran VC2_ROT6 FIND V(vc2_mon) WHEN V(rot_flag)=2.5 FALL=6
.meas tran VC3_ROT6 FIND V(vc3_mon) WHEN V(rot_flag)=2.5 FALL=6
.meas tran T_ROT7 WHEN V(rot_flag)=2.5 FALL=7
.meas tran VOUT_ROT7 FIND V(out) WHEN V(rot_flag)=2.5 FALL=7
.meas tran VC1_ROT7 FIND V(vc1_mon) WHEN V(rot_flag)=2.5 FALL=7
.meas tran VC2_ROT7 FIND V(vc2_mon) WHEN V(rot_flag)=2.5 FALL=7
.meas tran VC3_ROT7 FIND V(vc3_mon) WHEN V(rot_flag)=2.5 FALL=7
.meas tran T_ROT8 WHEN V(rot_flag)=2.5 FALL=8
.meas tran VOUT_ROT8 FIND V(out) WHEN V(rot_flag)=2.5 FALL=8
.meas tran VC1_ROT8 FIND V(vc1_mon) WHEN V(rot_flag)=2.5 FALL=8
.meas tran VC2_ROT8 FIND V(vc2_mon) WHEN V(rot_flag)=2.5 FALL=8
.meas tran VC3_ROT8 FIND V(vc3_mon) WHEN V(rot_flag)=2.5 FALL=8

.options plotwinsize=0 reltol=1e-5 abstol=1e-9 chgtol=1e-16 solver=alt cshunt=1e-15
.save V(vc1_mon) V(vc2_mon) V(vc3_mon) V(state_mon) V(rot_flag) V(handoff_flag) V(out) I(XMOD:L1) I(XMOD:L2) I(XMOD:L3) I(XMOD:L4) I(XMOD:CS1) I(XMOD:CS2) I(XMOD:CS3)
.tran 0 3.000000e-06 0 5.000e-11 UIC

.subckt SCB4P_P24_R04E9 vin out g gh1_in gl1_in gh2_in gl2_in gh3_in gl3_in gh4_in gl4_in
BGH1 gh1 g V=V(gh1_in,g)
BGL1 gl1 g V=V(gl1_in,g)
BGH2 gh2 g V=V(gh2_in,g)
BGL2 gl2 g V=V(gl2_in,g)
BGH3 gh3 g V=V(gh3_in,g)
BGL3 gl3 g V=V(gl3_in,g)
BGH4 gh4 g V=V(gh4_in,g)
BGL4 gl4 g V=V(gl4_in,g)

SH1 vin a1 gh1 g SWH
CH1 vin a1 {CH} ic=0
CS1 a1 x1 {CFLY} ic=0
CL1 x1 g {CL} ic=0
SL1 x1 g gl1 g SWL
L1 x1 out {LPHASE} Rser={RLDAMP} ic=0
SH2 a1 a2 gh2 g SWH
CS2 a2 x2 {CFLY} ic=0
SL2 x2 g gl2 g SWL
L2 x2 out {LPHASE} Rser={RLDAMP} ic=0
SH3 a2 a3 gh3 g SWH
CS3 a3 x3 {CFLY} ic=0
SL3 x3 g gl3 g SWL
L3 x3 out {LPHASE} Rser={RLDAMP} ic=0
SH4 a3 x4 gh4 g SWH
SL4 x4 g gl4 g SWL
L4 x4 out {LPHASE} Rser={RLDAMP} ic=0

RNUM_A1 a1 g 1Meg
RNUM_X1 x1 g 1Meg
RNUM_A2 a2 g 1Meg
RNUM_X2 x2 g 1Meg
RNUM_A3 a3 g 1Meg
RNUM_X3 x3 g 1Meg
RNUM_X4 x4 g 1Meg
.model SWH SW(Ron={RHS} Roff=1T Vt=2.5 Vh=0)
.model SWL SW(Ron={RLS} Roff=1T Vt=2.5 Vh=0)
.ends SCB4P_P24_R04E9
.end
