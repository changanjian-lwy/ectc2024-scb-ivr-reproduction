* R04E16 pilot - isolated gate-generation formula check, TSTART=0
* PURPOSE: verify BH1..BH4/BL1..BL4 (copied unchanged from R03A except
* TSTART=0) actually toggle correctly from t=0 in the fixed T/4-shifted
* pattern, and are not silently disabled by some leftover TSTART-dependent
* condition, BEFORE trusting the full 6-cell grid (BOUNDARY.md's own
* stated pilot-first discipline). No power stage, no Vin ramp, no load --
* the gate B-sources in isolation only, each tied directly to node 0 as
* an ideal voltage source (identical usage pattern to the full netlist's
* own "ghN 0"/"glN 0" node convention, so no floating-node concern here).

.param VIN=48 VOUT=1 POUT=250 NP=4 FSW=5Meg T={1/FSW}
.param D={NP*VOUT/VIN} TON={D*T} TSTART=0 VGATE=5

BH1 gh1 0 V=if(time>=TSTART & mod(time-TSTART+T,T)<TON,VGATE,0)
BL1 gl1 0 V=if(time<TSTART | mod(time-TSTART+T,T)>=TON,VGATE,0)
BH2 gh2 0 V=if(time>=TSTART & mod(time-TSTART+T-T/4,T)<TON,VGATE,0)
BL2 gl2 0 V=if(time<TSTART | mod(time-TSTART+T-T/4,T)>=TON,VGATE,0)
BH3 gh3 0 V=if(time>=TSTART & mod(time-TSTART+T-T/2,T)<TON,VGATE,0)
BL3 gl3 0 V=if(time<TSTART | mod(time-TSTART+T-T/2,T)>=TON,VGATE,0)
BH4 gh4 0 V=if(time>=TSTART & mod(time-TSTART+T-3*T/4,T)<TON,VGATE,0)
BL4 gl4 0 V=if(time<TSTART | mod(time-TSTART+T-3*T/4,T)>=TON,VGATE,0)

.meas tran GH1_AT_0 FIND V(gh1) AT 0
.meas tran GL1_AT_0 FIND V(gl1) AT 0
.meas tran GH1_RISE1 WHEN V(gh1)=2.5 RISE=1
.meas tran GH1_FALL1 WHEN V(gh1)=2.5 FALL=1
.meas tran GH2_RISE1 WHEN V(gh2)=2.5 RISE=1
.meas tran GH2_FALL1 WHEN V(gh2)=2.5 FALL=1
.meas tran GH3_RISE1 WHEN V(gh3)=2.5 RISE=1
.meas tran GH3_FALL1 WHEN V(gh3)=2.5 FALL=1
.meas tran GH4_RISE1 WHEN V(gh4)=2.5 RISE=1
.meas tran GH4_FALL1 WHEN V(gh4)=2.5 FALL=1
.meas tran GH1_RISE2 WHEN V(gh1)=2.5 RISE=2
.meas tran TON_MEAS PARAM GH1_FALL1-GH1_RISE1
.meas tran T_MEAS PARAM GH1_RISE2-GH1_RISE1
.meas tran PHASE21_MEAS PARAM GH2_RISE1-GH1_RISE1
.meas tran PHASE32_MEAS PARAM GH3_RISE1-GH2_RISE1
.meas tran PHASE43_MEAS PARAM GH4_RISE1-GH3_RISE1

.options reltol=1e-6 abstol=1e-9
.save V(gh1) V(gh2) V(gh3) V(gh4) V(gl1) V(gl2) V(gl3) V(gl4)
.tran 0 1u 0 10p UIC
.end
